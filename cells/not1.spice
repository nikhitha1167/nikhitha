.subckt not1 a vdd vss z

xm01 z a vdd vdd sky130_fd_pr__pfet_01v8 l=0.15 w=1.26
xm02 z a vss vss sky130_fd_pr__nfet_01v8 l=0.15 w=0.42

.ends not1

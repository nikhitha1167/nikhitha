* NGSPICE file created from dflipflop.ext - technology: sky130A

.lib /foss/pdks/sky130A/libs.tech/ngspice/sky130.lib.spice tt

.subckt dflipflop D CLK VDD VSS Q
X0 a_3858_283# a_330_84# a_2064_84# VSS sky130_fd_pr__nfet_01v8 ad=0.1764 pd=1.68 as=0.1764 ps=1.68 w=0.42 l=0.15
X1 a_1298_283# a_330_84# a_864_84# VDD sky130_fd_pr__pfet_01v8 ad=0.5292 pd=3.36 as=0.5292 ps=3.36 w=1.26 l=0.15
X2 a_4624_84# a_3858_283# VSS VSS sky130_fd_pr__nfet_01v8 ad=0.1764 pd=1.68 as=0.1764 ps=1.68 w=0.42 l=0.15
X3 a_1298_283# CLK a_2664_84# VDD sky130_fd_pr__pfet_01v8 ad=0.5292 pd=3.36 as=0.5292 ps=3.36 w=1.26 l=0.15
X4 a_864_84# D VDD VDD sky130_fd_pr__pfet_01v8 ad=0.5292 pd=3.36 as=0.5292 ps=3.36 w=1.26 l=0.15
X5 Q a_4624_84# VSS VSS sky130_fd_pr__nfet_01v8 ad=0.1764 pd=1.68 as=0.1764 ps=1.68 w=0.42 l=0.15
X6 Q a_4624_84# VDD VDD sky130_fd_pr__pfet_01v8 ad=0.5292 pd=3.36 as=0.5292 ps=3.36 w=1.26 l=0.15
X7 a_2664_84# a_2064_84# VSS VSS sky130_fd_pr__nfet_01v8 ad=0.1764 pd=1.68 as=0.1764 ps=1.68 w=0.42 l=0.15
X8 a_2064_84# a_1298_283# VDD VDD sky130_fd_pr__pfet_01v8 ad=0.5292 pd=3.36 as=0.5292 ps=3.36 w=1.26 l=0.15
X9 a_1298_283# a_330_84# a_2664_84# VSS sky130_fd_pr__nfet_01v8 ad=0.1764 pd=1.68 as=0.1764 ps=1.68 w=0.42 l=0.15
X10 a_1298_283# CLK a_864_84# VSS sky130_fd_pr__nfet_01v8 ad=0.1764 pd=1.68 as=0.1764 ps=1.68 w=0.42 l=0.15
X11 a_2664_84# a_2064_84# VDD VDD sky130_fd_pr__pfet_01v8 ad=0.5292 pd=3.36 as=0.5292 ps=3.36 w=1.26 l=0.15
X12 a_3858_283# CLK a_5224_84# VSS sky130_fd_pr__nfet_01v8 ad=0.1764 pd=1.68 as=0.1764 ps=1.68 w=0.42 l=0.15
X13 a_330_84# CLK VDD VDD sky130_fd_pr__pfet_01v8 ad=0.5292 pd=3.36 as=0.5292 ps=3.36 w=1.26 l=0.15
X14 a_330_84# CLK VSS VSS sky130_fd_pr__nfet_01v8 ad=0.1764 pd=1.68 as=0.1764 ps=1.68 w=0.42 l=0.15
X15 a_3858_283# CLK a_2064_84# VDD sky130_fd_pr__pfet_01v8 ad=0.5292 pd=3.36 as=0.5292 ps=3.36 w=1.26 l=0.15
X16 a_864_84# D VSS VSS sky130_fd_pr__nfet_01v8 ad=0.1764 pd=1.68 as=0.1764 ps=1.68 w=0.42 l=0.15
X17 a_5224_84# a_4624_84# VSS VSS sky130_fd_pr__nfet_01v8 ad=0.1764 pd=1.68 as=0.1764 ps=1.68 w=0.42 l=0.15
X18 a_3858_283# a_330_84# a_5224_84# VDD sky130_fd_pr__pfet_01v8 ad=0.5292 pd=3.36 as=0.5292 ps=3.36 w=1.26 l=0.15
X19 a_5224_84# a_4624_84# VDD VDD sky130_fd_pr__pfet_01v8 ad=0.5292 pd=3.36 as=0.5292 ps=3.36 w=1.26 l=0.15
X20 a_4624_84# a_3858_283# VDD VDD sky130_fd_pr__pfet_01v8 ad=0.5292 pd=3.36 as=0.5292 ps=3.36 w=1.26 l=0.15
X21 a_2064_84# a_1298_283# VSS VSS sky130_fd_pr__nfet_01v8 ad=0.1764 pd=1.68 as=0.1764 ps=1.68 w=0.42 l=0.15
C0 a_4624_84# a_330_84# 0.10121f
C1 a_864_84# a_1298_283# 0.19526f
C2 a_330_84# a_2064_84# 0.16971f
C3 D a_330_84# 0.06773f
C4 CLK a_330_84# 1.31217f
C5 Q a_330_84# 0
C6 a_2664_84# a_1298_283# 0.30498f
C7 a_864_84# a_2064_84# 0
C8 a_864_84# D 0.03159f
C9 CLK a_864_84# 0.06202f
C10 a_1298_283# a_2064_84# 0.50204f
C11 D a_1298_283# 0
C12 a_2664_84# a_2064_84# 0.14301f
C13 CLK a_1298_283# 0.35983f
C14 CLK a_2664_84# 0.15529f
C15 a_4624_84# a_5224_84# 0.14305f
C16 a_5224_84# a_2064_84# 0
C17 a_4624_84# a_2064_84# 0.00379f
C18 D a_2064_84# 0
C19 CLK a_5224_84# 0.04014f
C20 CLK a_4624_84# 0.48294f
C21 CLK a_2064_84# 0.71004f
C22 CLK D 0.02202f
C23 Q a_4624_84# 0.03334f
C24 Q CLK 0.00239f
C25 VDD a_3858_283# 1.01314f
C26 a_3858_283# a_330_84# 0.68359f
C27 VDD a_330_84# 1.4016f
C28 a_864_84# VDD 0.31238f
C29 a_1298_283# a_3858_283# 0
C30 a_2664_84# a_3858_283# 0
C31 a_1298_283# VDD 0.92663f
C32 a_2664_84# VDD 0.30692f
C33 a_5224_84# a_3858_283# 0.30669f
C34 a_864_84# a_330_84# 0.18832f
C35 a_4624_84# a_3858_283# 0.44626f
C36 a_3858_283# a_2064_84# 0.21551f
C37 a_5224_84# VDD 0.30517f
C38 a_4624_84# VDD 0.54904f
C39 VDD a_2064_84# 0.56079f
C40 D VDD 0.16202f
C41 a_1298_283# a_330_84# 0.4758f
C42 CLK a_3858_283# 0.15761f
C43 a_2664_84# a_330_84# 0.05619f
C44 Q a_3858_283# 0.00306f
C45 CLK VDD 0.71692f
C46 Q VDD 0.11652f
C47 a_5224_84# a_330_84# 0.15014f
C48 Q VSS 0.15279f
C49 D VSS 0.27822f
C50 CLK VSS 3.93171f
C51 VDD VSS 8.56585f
C52 a_5224_84# VSS 0.31559f
C53 a_4624_84# VSS 1.64925f
C54 a_3858_283# VSS 0.57431f
C55 a_2664_84# VSS 0.31396f
C56 a_2064_84# VSS 1.62797f
C57 a_1298_283# VSS 0.59284f
C58 a_864_84# VSS 0.36302f
C59 a_330_84# VSS 1.80843f
.ends
